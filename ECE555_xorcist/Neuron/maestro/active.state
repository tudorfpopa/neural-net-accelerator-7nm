ADE simulation setup
Test ECE555_xorcist_Neuron_1: ECE555_xorcist/Neuron/schematic, simulator hspiceD
Run mode: Single Run, Sweeps and Corners
