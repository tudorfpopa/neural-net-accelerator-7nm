ADE simulation setup
Run mode: Single Run, Sweeps and Corners
Tests:
  ECE555_xorcist_Neuron_1: ECE555_xorcist/Neuron/schematic, simulator hspiceD
