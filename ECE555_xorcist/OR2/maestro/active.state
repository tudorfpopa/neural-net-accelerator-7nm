ADE simulation setup
Test ECE555_xorcist_OR2_1: ECE555_xorcist/OR2/schematic, simulator hspiceD
Run mode: Single Run, Sweeps and Corners
