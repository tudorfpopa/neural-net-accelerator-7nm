ADE simulation setup
Run mode: Single Run, Sweeps and Corners
Tests:
  ECE555_xorcist_OR2_1: ECE555_xorcist/OR2/schematic, simulator hspiceD
