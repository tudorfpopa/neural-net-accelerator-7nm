ADE simulation setup
Run mode: Single Run, Sweeps and Corners
Tests:
  ECE555_xorcist_XOR2_4T_1: ECE555_xorcist/XOR2_4T/schematic, simulator hspiceD
