ADE simulation setup
Test ECE555_xorcist_XOR2_4T_1: ECE555_xorcist/XOR2_4T/schematic, simulator hspiceD
Run mode: Single Run, Sweeps and Corners
