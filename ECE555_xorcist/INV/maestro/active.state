ADE simulation setup
Test ECE555_xorcist_INV_1: ECE555_xorcist/INV/schematic, simulator hspiceD
Run mode: Single Run, Sweeps and Corners
