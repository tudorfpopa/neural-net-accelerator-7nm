ADE simulation setup
Run mode: Single Run, Sweeps and Corners
Tests:
  ECE555_xorcist_INV_1: ECE555_xorcist/INV/schematic, simulator hspiceD
