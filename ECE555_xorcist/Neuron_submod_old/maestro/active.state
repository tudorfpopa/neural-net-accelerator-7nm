ADE simulation setup
Test ECE555_xorcist_Neuron_submod_1: ECE555_xorcist/Neuron_submod/schematic, simulator hspiceD
