ADE simulation setup
Run mode: Single Run, Sweeps and Corners
Tests:
  ECE555_xorcist_ADDR2_OPT_1: ECE555_xorcist/ADDR2_OPT/schematic, simulator hspiceD
