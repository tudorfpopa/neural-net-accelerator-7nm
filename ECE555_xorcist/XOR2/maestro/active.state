ADE simulation setup
Test ECE555_xorcist_XOR2_test_1: ECE555_xorcist/XOR2/schematic, simulator hspiceD
Run mode: Single Run, Sweeps and Corners
